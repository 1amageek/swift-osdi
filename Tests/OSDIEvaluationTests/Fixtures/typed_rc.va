nature Voltage;
    units = "V";
    access = V;
endnature
nature Current;
    units = "A";
    access = I;
endnature
discipline electrical;
    potential Voltage;
    flow Current;
enddiscipline
module typed_rc(p, n);
    inout p, n;
    electrical p, n;
    parameter real conductance = 1.0e-3 from (0:inf);
    aliasparam gain = conductance;
    parameter integer polarity = 1 from [-1:1] exclude 0;
    parameter string mode = "normal";
    (* type = "instance" *) parameter real scale = 1.0 from (0:inf);
    aliasparam scale_alias = scale;
    (* type = "instance" *) parameter integer fingers = 1 from [1:16];
    real effective;
    analog begin
        effective = conductance * scale * fingers * polarity;
        if (mode == "boost") effective = effective * 2.0;
        if ($param_given(scale)) effective = effective * 1.25;
        effective = effective * (1.0 + 0.001 * ($temperature - 300.15));
        I(p, n) <+ effective * V(p, n);
        I(p, n) <+ ddt(2.0e-12 * scale * V(p, n));
    end
endmodule
